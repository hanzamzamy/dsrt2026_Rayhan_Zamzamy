** sch_path: /workspace/project/parity_ceker/testbench/tb_even_parity_gen.sch
**.subckt tb_even_parity_gen OUT_PARITY IN_0 IN_1 IN_2 IN_3 IN_4 IN_5 IN_6 IN_7
*.opin OUT_PARITY
*.ipin IN_0
*.ipin IN_1
*.ipin IN_2
*.ipin IN_3
*.ipin IN_4
*.ipin IN_5
*.ipin IN_6
*.ipin IN_7
x1 VDD 0 IN_0 IN_1 IN_2 IN_3 OUT_PARITY IN_4 IN_5 IN_6 IN_7 even_parity_gen
**** begin user architecture code

.lib /foss/pdks/sky130A/libs.tech/ngspice/sky130.lib.spice tt

* --- 0. VOLTAGE SOURCES (Power & 8-Bit Stimulus) ---
V_SUPPLY VDD 0 1.8

* Binary Counter Pattern: Periods double to test logic combinations
V_IN0 IN_0 0 pulse(0 1.8 1ns 100ps 100ps 4ns 10ns)
V_IN1 IN_1 0 pulse(0 1.8 1ns 100ps 100ps 9ns 20ns)
V_IN2 IN_2 0 pulse(0 1.8 1ns 100ps 100ps 19ns 40ns)
V_IN3 IN_3 0 pulse(0 1.8 1ns 100ps 100ps 39ns 80ns)
V_IN4 IN_4 0 pulse(0 1.8 1ns 100ps 100ps 79ns 160ns)
V_IN5 IN_5 0 pulse(0 1.8 1ns 100ps 100ps 159ns 320ns)
V_IN6 IN_6 0 pulse(0 1.8 1ns 100ps 100ps 319ns 640ns)
V_IN7 IN_7 0 pulse(0 1.8 1ns 100ps 100ps 639ns 1280ns)

* --- 1. SIMULATION COMMANDS ---
* Run for 200ns to capture a high variety of transition states
.tran 20p 200n
.save all

.control
  run

  * --- DIGITAL VERIFICATION ---
  * Convert analog voltages to binary 1 or 0
  let b0 = v(in_0) > 0.9
  let b1 = v(in_1) > 0.9
  let b2 = v(in_2) > 0.9
  let b3 = v(in_3) > 0.9
  let b4 = v(in_4) > 0.9
  let b5 = v(in_5) > 0.9
  let b6 = v(in_6) > 0.9
  let b7 = v(in_7) > 0.9

  * Sum the bits
  let sum_bits = b0 + b1 + b2 + b3 + b4 + b5 + b6 + b7

  * Calculate Modulo 2
  let mod_2 = sum_bits - 2 * floor(sum_bits / 2)

  * If sum is even (mod_2 = 0), output 1.8V.
  * If sum is odd (mod_2 = 1), output 0V.
  let ideal_parity = (1 - mod_2) * 1.8

  * Plot your physical output against the mathematical ideal
  setplot tran1
  plot v(out_parity) ideal_parity title 'Physical Output vs Ideal Mathematical Parity'

  * --- 2. VISUAL THEME ---
  set color0=white
  set color1=black
  set color2=red
  set color3=blue
  set color4=darkgreen
  set xbrushwidth=3

  * --- 3. TIMING & POWER ANALYSIS ---
  setplot tran1

  * Measure Worst-Case Path Delay
  * IN_0 is the fastest switching input. We measure how long it takes to reach the output.
  meas tran t_delay trig v(in_0) val=0.9 cross=1 targ v(out_parity) val=0.9 cross=1

  * Power Analysis
  meas tran avg_i avg i(V_SUPPLY)
  let p_dyn = avg_i * 1.8 * -1

  * Measure static leakage at a stable resting point (199ns)
  meas tran leak_i find i(V_SUPPLY) at=199n
  let p_stat = leak_i * 1.8 * -1

  let pdp = p_dyn * t_delay

  * Cumulative Energy Integration (using integ, not sdt)
  let inst_power = -i(V_SUPPLY) * 1.8
  let total_energy = integ(inst_power)

  * --- 4. EXPORT CLEAN REPORT ---
  echo === 8-BIT PARITY TREE REPORT === > report.txt
  echo Worst-Case Path Delay: >> report.txt
  print t_delay >> report.txt
  echo Average Dynamic Power: >> report.txt
  print p_dyn >> report.txt
  echo Static Leakage Power: >> report.txt
  print p_stat >> report.txt
  echo Power Delay Product: >> report.txt
  print pdp >> report.txt

  * --- 5. EXPORT RAW DATA FOR GAW / GTKWAVE ---
  * This is critical for reading 8 inputs clearly
  write parity_tree_sim.raw

  * --- 6. EXPORT PLOTS (SVG) ---
  set hcopydevtype=svg

  * Split inputs so the graphs are readable
  hardcopy tran_inputs_0_3.svg v(in_0) v(in_1) v(in_2) v(in_3) title 'Inputs 0-3 (Fast)'
  hardcopy tran_inputs_4_7.svg v(in_4) v(in_5) v(in_6) v(in_7) title 'Inputs 4-7 (Slow)'
  hardcopy tran_output.svg v(out_parity) title 'Even Parity Output'
  hardcopy tran_current.svg -i(V_SUPPLY) title 'Total Supply Current'
  hardcopy tran_energy.svg total_energy title 'Cumulative Energy Consumption'

  * Save Digital Verification Plot
  hardcopy tran_verification.svg v(out_parity) ideal_parity title 'Verification: Physical vs Ideal Parity'

  * --- 7. SHOW PLOTS ON SCREEN ---
  plot v(in_0) v(in_1) v(in_2) v(in_3) title 'Lower 4 Bits (IN_0 to IN_3)'
  plot v(in_4) v(in_5) v(in_6) v(in_7) title 'Upper 4 Bits (IN_4 to IN_7)'
  plot v(out_parity) title '8-Bit Even Parity Output'
  plot -i(V_SUPPLY) title 'Total Supply Current'
  plot total_energy title 'Cumulative Energy'
.endc

**** end user architecture code
**.ends

* expanding   symbol:  schematic/even_parity_gen.sym # of pins=11
** sym_path: /workspace/project/parity_ceker/schematic/even_parity_gen.sym
** sch_path: /workspace/project/parity_ceker/schematic/even_parity_gen.sch
.subckt even_parity_gen VDD GND I0 I1 I2 I3 O0 I4 I5 I6 I7
*.iopin VDD
*.iopin GND
*.ipin I0
*.ipin I1
*.ipin I2
*.ipin I3
*.ipin I4
*.ipin I5
*.ipin I6
*.ipin I7
*.opin O0
x1 VDD I0 net1 I1 GND xnor_6t_buf
x2 VDD I2 net2 I3 GND xnor_6t_buf
x3 VDD I4 net3 I5 GND xnor_6t_buf
x4 VDD I6 net4 I7 GND xnor_6t_buf
x5 VDD net1 net6 net2 GND xnor_6t_buf
x6 VDD net3 net5 net4 GND xnor_6t_buf
x7 VDD net6 net7 net5 GND xnor_6t_buf
x8 VDD net7 O0 GND not_std
.ends

* expanding   symbol:  schematic/xnor_6t_buf.sym # of pins=5
** sym_path: /workspace/project/parity_ceker/schematic/xnor_6t_buf.sym
** sch_path: /workspace/project/parity_ceker/schematic/xnor_6t_buf.sch
.subckt xnor_6t_buf VDD A Y B GND
*.ipin A
*.ipin B
*.opin Y
*.iopin VDD
*.iopin GND
x1 VDD net1 A B GND xor_6t
x2 VDD net1 Y GND not_std
.ends

* expanding   symbol:  schematic/not_std.sym # of pins=4
** sym_path: /workspace/project/parity_ceker/schematic/not_std.sym
** sch_path: /workspace/project/parity_ceker/schematic/not_std.sch
.subckt not_std VDD A Y GND
*.ipin A
*.opin Y
*.iopin VDD
*.iopin GND
XM1 Y A VDD VDD sky130_fd_pr__pfet_01v8 L=0.15 W=2 nf=1 ad=0.58 as=0.58 pd=4.58 ps=4.58 nrd=0.145 nrs=0.145 sa=0 sb=0 sd=0 mult=1
XM2 Y A GND GND sky130_fd_pr__nfet_01v8 L=0.15 W=1 nf=1 ad=0.29 as=0.29 pd=2.58 ps=2.58 nrd=0.29 nrs=0.29 sa=0 sb=0 sd=0 mult=1
.ends

* expanding   symbol:  schematic/xor_6t.sym # of pins=5
** sym_path: /workspace/project/parity_ceker/schematic/xor_6t.sym
** sch_path: /workspace/project/parity_ceker/schematic/xor_6t.sch
.subckt xor_6t VDD Y A B GND
*.ipin A
*.opin Y
*.iopin VDD
*.iopin GND
*.ipin B
XM1 net1 A VDD VDD sky130_fd_pr__pfet_01v8 L=0.15 W=2 nf=1 ad=0.58 as=0.58 pd=4.58 ps=4.58 nrd=0.145 nrs=0.145 sa=0 sb=0 sd=0
+ mult=1
XM2 net1 A GND GND sky130_fd_pr__nfet_01v8 L=0.15 W=1 nf=1 ad=0.29 as=0.29 pd=2.58 ps=2.58 nrd=0.29 nrs=0.29 sa=0 sb=0 sd=0 mult=1
XM3 Y B A VDD sky130_fd_pr__pfet_01v8 L=0.15 W=2 nf=1 ad=0.58 as=0.58 pd=4.58 ps=4.58 nrd=0.145 nrs=0.145 sa=0 sb=0 sd=0 mult=1
XM4 Y B net1 GND sky130_fd_pr__nfet_01v8 L=0.15 W=1 nf=1 ad=0.29 as=0.29 pd=2.58 ps=2.58 nrd=0.29 nrs=0.29 sa=0 sb=0 sd=0 mult=1
XM5 Y A B VDD sky130_fd_pr__pfet_01v8 L=0.15 W=2 nf=1 ad=0.58 as=0.58 pd=4.58 ps=4.58 nrd=0.145 nrs=0.145 sa=0 sb=0 sd=0 mult=1
XM6 Y net1 B GND sky130_fd_pr__nfet_01v8 L=0.15 W=1 nf=1 ad=0.29 as=0.29 pd=2.58 ps=2.58 nrd=0.29 nrs=0.29 sa=0 sb=0 sd=0 mult=1
.ends

.GLOBAL VDD
.end
