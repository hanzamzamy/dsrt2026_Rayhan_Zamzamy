.lib /foss/pdks/sky130A/libs.tech/ngspice/sky130.lib.spice tt

* --- VOLTAGE SOURCES ---
V_SUPPLY VDD 0 1.8
* IN_A period is 40ns, IN_B period is 20ns to test all 4 states (00, 01, 10, 11)
V_A IN_A 0 pulse(0 1.8 1ns 100ps 100ps 19ns 40ns)
V_B IN_B 0 pulse(0 1.8 2ns 100ps 100ps 9ns 20ns)

* --- SIMULATION COMMANDS ---
.tran 10p 100n
.dc V_A 0 1.8 0.01
.save all

.control
  run

  * --- VISUAL THEME ---
  set color0=white
  set color1=black
  set color2=red
  set color3=blue
  set color4=darkgreen
  set xbrushwidth=3

  * --- TIMING & POWER ANALYSIS ---
  setplot tran1

  * Universal Delay: measures time between first input crossing and first output crossing
  meas tran t_delay trig v(in_a) val=0.9 cross=1 targ v(y) val=0.9 cross=1

  * --- RISE & FALL TIME MEASUREMENTS ---
  * Rise Time: Time to go from 10% (0.18V) to 90% (1.62V) on the first rising edge
  meas tran t_rise trig v(y) val=0.18 rise=1 targ v(y) val=1.62 rise=1

  * Fall Time: Time to go from 90% (1.62V) to 10% (0.18V) on the first falling edge
  meas tran t_fall trig v(y) val=1.62 fall=1 targ v(y) val=0.18 fall=1

  * Power Analysis
  meas tran avg_i avg i(V_SUPPLY)
  let p_dyn = avg_i * 1.8 * -1

  meas tran leak_i find i(V_SUPPLY) at=99n
  let p_stat = leak_i * 1.8 * -1

  let pdp = p_dyn * t_delay

  * --- EXPORT CLEAN REPORT ---
  echo === XOR 6T GATE REPORT === > report.txt
  echo Propagation Delay: >> report.txt
  print t_delay >> report.txt
  echo Rise Time: >> report.txt
  print t_rise >> report.txt
  echo Fall Time: >> report.txt
  print t_fall >> report.txt
  echo Dynamic Power: >> report.txt
  print p_dyn >> report.txt
  echo Static Power: >> report.txt
  print p_stat >> report.txt
  echo Power Delay Product: >> report.txt
  print pdp >> report.txt

  * --- ADVANCED DATA PROCESSING & RAW EXPORT ---
  setplot tran1
  let inst_power = -i(V_SUPPLY) * 1.8
  let total_energy = integ(inst_power)

  write xor_6t_gate.raw

  * --- EXPORT PLOTS (SVG) ---
  set hcopydevtype=svg

  * Save DC Sweeps
  setplot dc1
  hardcopy dc_vtc.svg v(y) vs v(in_a) title 'DC: VTC'
  hardcopy dc_gain.svg v(y) vs v(in_a) deriv(v(y)) xl 0 1.8 yl -5 1.8 title 'DC: VTC and Noise Margins'

  * Save Transient Plots (Separated cleanly)
  setplot tran1
  hardcopy tran_inputs.svg v(in_a) v(in_b) title 'Transient: Logic Inputs'
  hardcopy tran_output.svg v(y) title 'Transient: Logic Output'
  hardcopy tran_current.svg -i(V_SUPPLY) title 'Transient: Total Supply Current'
  hardcopy tran_energy.svg total_energy title 'Transient: Cumulative Energy'
  hardcopy tran_leakage.svg -i(V_SUPPLY) yl 0 100n title 'Transient: Static Leakage Zoom'

  * --- SHOW PLOTS ON SCREEN ---
  * DC Plots
  setplot dc1
  plot v(y) vs v(in_a) title 'VTC'
  plot v(y) vs v(in_a) deriv(v(y)) xl 0 1.8 yl -5 1.8 title 'VTC and Noise Margins'

  * Transient Plots (Separated cleanly)
  setplot tran1
  plot v(in_a) v(in_b) title 'Logic Inputs (IN_A, IN_B)'
  plot v(y) title 'Logic Output (Y)'
  plot -i(V_SUPPLY) title 'Total Supply Current (Crowbar & Dynamic)'
  plot total_energy title 'Cumulative Energy Consumption'
  plot -i(V_SUPPLY) yl 0 100n title 'Static Leakage Current Zoom'
.endc
