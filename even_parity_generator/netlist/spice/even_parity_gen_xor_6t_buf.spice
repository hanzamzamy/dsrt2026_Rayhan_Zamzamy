** sch_path: /workspace/project/even_parity_generator/schematic/even_parity_gen_xor_6t_buf.sch
**.subckt even_parity_gen_xor_6t_buf VDD GND I0 I1 I2 I3 O0 I4 I5 I6 I7
*.iopin VDD
*.iopin GND
*.ipin I0
*.ipin I1
*.ipin I2
*.ipin I3
*.ipin I4
*.ipin I5
*.ipin I6
*.ipin I7
*.opin O0
x1 VDD net1 I0 I1 GND xor_6t
x2 VDD net2 I2 I3 GND xor_6t
x3 VDD net3 I4 I5 GND xor_6t
x4 VDD net4 I6 I7 GND xor_6t
x5 VDD net6 net1 net2 GND xor_6t
x6 VDD net5 net3 net4 GND xor_6t
x7 VDD net7 net6 net5 GND xor_6t
x8 VDD net7 net8 GND not_std
x9 VDD net8 O0 GND not_std
**.ends

* expanding   symbol:  schematic/xor_6t.sym # of pins=5
** sym_path: /workspace/project/even_parity_generator/schematic/xor_6t.sym
** sch_path: /workspace/project/even_parity_generator/schematic/xor_6t.sch
.subckt xor_6t VDD Y A B GND
*.ipin A
*.opin Y
*.iopin VDD
*.iopin GND
*.ipin B
XM1 net1 A VDD VDD sky130_fd_pr__pfet_01v8 L=0.15 W=2 nf=1 ad=0.58 as=0.58 pd=4.58 ps=4.58 nrd=0.145 nrs=0.145 sa=0 sb=0 sd=0
+ mult=1
XM2 net1 A GND GND sky130_fd_pr__nfet_01v8 L=0.15 W=1 nf=1 ad=0.29 as=0.29 pd=2.58 ps=2.58 nrd=0.29 nrs=0.29 sa=0 sb=0 sd=0 mult=1
XM3 Y B A VDD sky130_fd_pr__pfet_01v8 L=0.15 W=2 nf=1 ad=0.58 as=0.58 pd=4.58 ps=4.58 nrd=0.145 nrs=0.145 sa=0 sb=0 sd=0 mult=1
XM4 Y B net1 GND sky130_fd_pr__nfet_01v8 L=0.15 W=1 nf=1 ad=0.29 as=0.29 pd=2.58 ps=2.58 nrd=0.29 nrs=0.29 sa=0 sb=0 sd=0 mult=1
XM5 Y A B VDD sky130_fd_pr__pfet_01v8 L=0.15 W=2 nf=1 ad=0.58 as=0.58 pd=4.58 ps=4.58 nrd=0.145 nrs=0.145 sa=0 sb=0 sd=0 mult=1
XM6 Y net1 B GND sky130_fd_pr__nfet_01v8 L=0.15 W=1 nf=1 ad=0.29 as=0.29 pd=2.58 ps=2.58 nrd=0.29 nrs=0.29 sa=0 sb=0 sd=0 mult=1
.ends

* expanding   symbol:  schematic/not_std.sym # of pins=4
** sym_path: /workspace/project/even_parity_generator/schematic/not_std.sym
** sch_path: /workspace/project/even_parity_generator/schematic/not_std.sch
.subckt not_std VDD A Y GND
*.ipin A
*.opin Y
*.iopin VDD
*.iopin GND
XM1 Y A VDD VDD sky130_fd_pr__pfet_01v8 L=0.15 W=2 nf=1 ad=0.58 as=0.58 pd=4.58 ps=4.58 nrd=0.145 nrs=0.145 sa=0 sb=0 sd=0 mult=1
XM2 Y A GND GND sky130_fd_pr__nfet_01v8 L=0.15 W=1 nf=1 ad=0.29 as=0.29 pd=2.58 ps=2.58 nrd=0.29 nrs=0.29 sa=0 sb=0 sd=0 mult=1
.ends

.end
