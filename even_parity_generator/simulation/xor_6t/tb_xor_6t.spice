** sch_path: /workspace/project/even_parity_generator/testbench/spice/tb_xor_6t.sch
**.subckt tb_xor_6t IN_A Y IN_B
*.ipin IN_A
*.opin Y
*.ipin IN_B
x1 VDD Y IN_A IN_B 0 xor_6t
**** begin user architecture code

.include /workspace/project/even_parity_generator/testbench/spice/code/xor_6t.spice

**** end user architecture code
**.ends

* expanding   symbol:  schematic/xor_6t.sym # of pins=5
** sym_path: /workspace/project/even_parity_generator/schematic/xor_6t.sym
** sch_path: /workspace/project/even_parity_generator/schematic/xor_6t.sch
.subckt xor_6t VDD Y A B GND
*.ipin A
*.opin Y
*.iopin VDD
*.iopin GND
*.ipin B
XM1 net1 A VDD VDD sky130_fd_pr__pfet_01v8 L=0.15 W=2 nf=1 ad=0.58 as=0.58 pd=4.58 ps=4.58 nrd=0.145 nrs=0.145 sa=0 sb=0 sd=0
+ mult=1
XM2 net1 A GND GND sky130_fd_pr__nfet_01v8 L=0.15 W=1 nf=1 ad=0.29 as=0.29 pd=2.58 ps=2.58 nrd=0.29 nrs=0.29 sa=0 sb=0 sd=0 mult=1
XM3 Y B A VDD sky130_fd_pr__pfet_01v8 L=0.15 W=2 nf=1 ad=0.58 as=0.58 pd=4.58 ps=4.58 nrd=0.145 nrs=0.145 sa=0 sb=0 sd=0 mult=1
XM4 Y B net1 GND sky130_fd_pr__nfet_01v8 L=0.15 W=1 nf=1 ad=0.29 as=0.29 pd=2.58 ps=2.58 nrd=0.29 nrs=0.29 sa=0 sb=0 sd=0 mult=1
XM5 Y A B VDD sky130_fd_pr__pfet_01v8 L=0.15 W=2 nf=1 ad=0.58 as=0.58 pd=4.58 ps=4.58 nrd=0.145 nrs=0.145 sa=0 sb=0 sd=0 mult=1
XM6 Y net1 B GND sky130_fd_pr__nfet_01v8 L=0.15 W=1 nf=1 ad=0.29 as=0.29 pd=2.58 ps=2.58 nrd=0.29 nrs=0.29 sa=0 sb=0 sd=0 mult=1
.ends

.GLOBAL VDD
.end
